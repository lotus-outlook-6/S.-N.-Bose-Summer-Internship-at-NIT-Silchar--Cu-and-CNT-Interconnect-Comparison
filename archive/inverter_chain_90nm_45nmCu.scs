// ==================================================================
// Two-Stage 90nm CMOS Inverter Chain with 45nm-node Copper Interconnect
// Format: Cadence Spectre (native Virtuoso/ADE netlist format)
// Usage : spectre inverter_chain_90nm_45nmCu.scs
//         or include this file from an ADE-L "Include File" setup,
//         or paste the subckts into a Virtuoso schematic's netlist.
//
// NOTE ON MIXED NODES: the inverters below are still the original
// 90nm generic BSIM3 models (inv90/nmos90/pmos90) -- unchanged. Only
// the interconnect between them has been switched from the placeholder
// r_int/c_int/l_int values to real 45nm-node Cu values. The RLC
// spreadsheet has no transistor-level data, so there's nothing to pull
// for a "true" 45nm device; a fixed 90nm driver with a scaled wire is
// also the standard way to isolate the interconnect's own contribution
// to delay, which is presumably the point of this comparison.
// ==================================================================
simulator lang=spectre

// ------------------------------------------------------------------
// Global parameters
// ------------------------------------------------------------------
parameters vdd_val=1.2

// ------------------------------------------------------------------
// COPPER INTERCONNECT PARAMETERS -- 45nm node
// Source: CNT_Cu_RLC_Calculations_corrected.xlsx, Summary sheet,
// Node=45nm / Material=Cu. Values already include Fuchs-Sondheimer
// surface scattering + Mayadas-Shatzkes grain-boundary corrections
// (rho_eff = 2.4348 uOhm.cm, i.e. 2.43x bulk Cu at this node) and the
// Sakurai-Tamaru capacitance model -- do NOT recompute from bulk
// rho_cu in Option B below, that skips both corrections.
// ------------------------------------------------------------------
// Option A (active): lumped R, C, L direct from the sheet.
// Active length below = 100um. To change length, comment out the
// active block and uncomment one of the two alternates.

// -- 100um (ACTIVE) --
parameters r_int=877.71     // total wire resistance   [ohm]  @ l=100um
parameters c_int=3.2827f    // total wire capacitance  [F]    @ l=100um
parameters l_int=158.13p    // total wire inductance   [H]    @ l=100um

// -- 500um alternate (comment the 100um block above, uncomment this) --
// parameters r_int=4388.55    // [ohm]  @ l=500um
// parameters c_int=16.4135f   // [F]    @ l=500um
// parameters l_int=951.57p    // [H]    @ l=500um

// -- 1000um alternate --
// parameters r_int=8777.11    // [ohm]  @ l=1000um
// parameters c_int=32.827f    // [F]    @ l=1000um
// parameters l_int=2041.75p   // [H]    @ l=1000um

// Option B: derive R from bulk copper geometry instead (illustrative
// only -- simple rho*l/(W*H), no size-effect correction. At 45nm this
// underestimates R by ~2.4x vs Option A above; kept here for reference
// and geometry documentation, not meant to feed r_int directly.)
parameters wire_len=100u     // length     [m]
parameters wire_width=45n    // width  W   [m]  (45nm node)
parameters wire_thick=76.5n  // thick. H   [m]  (45nm node, H = 1.7*W)
parameters rho_cu=1.68e-8    // Cu bulk resistivity [ohm*m] (21C)
parameters r_int_calc=(rho_cu*wire_len)/(wire_width*wire_thick)
// To activate geometry-based (uncorrected) resistance, change the
// r_int parameter above to:   parameters r_int=r_int_calc

// ------------------------------------------------------------------
// 90nm generic MOS models (simplified, illustrative -- swap in your
// foundry's model library via an `include` statement for real silicon)
// ------------------------------------------------------------------
model nmos90 bsim3v3 type=n vth0=0.25 tox=2.2e-9 u0=300 lambda=0.10
model pmos90 bsim3v3 type=p vth0=-0.25 tox=2.2e-9 u0=100 lambda=0.10

// ------------------------------------------------------------------
// Inverter subcircuit (parameterized W/L so you can resize freely)
// ------------------------------------------------------------------
subckt inv90 in out vdd gnd \
        wn=120n wp=240n ln=90n
    MP0 (out in vdd vdd) pmos90 w=wp l=ln
    MN0 (out in gnd gnd) nmos90 w=wn l=ln
ends inv90

// ------------------------------------------------------------------
// Copper interconnect subcircuit: Pi RC(L) segment, node a -> node b
// Fully parameterized -- pass r=, c=, l= at instantiation to change
// the interconnect on the fly without touching this subckt.
// ------------------------------------------------------------------
subckt cu_interconnect a b gnd \
        r=50 c=5f l=1p
    Ca   (a gnd)  capacitor c=c/2
    Lint (a n_l)      inductor  l=l
    Rint (n_l b)      resistor  r=r
    Cb   (b gnd)      capacitor c=c/2
ends cu_interconnect

// ==================================================================
// Top-level circuit: in -> INV1 -> mid --(45nm Cu interconnect)--> in2 -> INV2 -> out
// ==================================================================

// Supplies / stimulus
Vdd  (vdd 0)  vsource dc=vdd_val type=dc
Vin  (in 0)   vsource type=pulse val0=0 val1=vdd_val delay=1n \
              rise=50p fall=50p width=2n period=4n

// Stage 1
Xinv1 (in mid vdd 0) inv90

// Interconnect between the two inverters -- 45nm-node Cu, l=100um
// (see Option A block above to switch to the 500um/1000um values)
Xint  (mid in2 0) cu_interconnect r=r_int c=c_int l=l_int

// Stage 2
Xinv2 (in2 out vdd 0) inv90

// Small fixed fanout load at the final output
CL (out 0) capacitor c=2f

// ------------------------------------------------------------------
// Analysis
// ------------------------------------------------------------------
tran1 tran stop=8n

// Save nodes of interest for the ADE waveform window / .raw output
save in mid in2 out vdd

// Optional delay measurements (uncomment in ADE "Outputs" or here)
// tpdHL delay trig=v(in) val=vdd_val/2 rise=1 targ=v(out) val=vdd_val/2 fall=1
// tpdLH delay trig=v(in) val=vdd_val/2 fall=1 targ=v(out) val=vdd_val/2 rise=1
